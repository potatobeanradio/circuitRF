* circuitRF transient deck: bench rlc, analysis TR1
* written by circuitRF 1.8.4
* names (deck = circuitRF):
*   net in = in
*   net a = a
*   net b = b
*   instance VS = VS
*   instance R1 = R1
*   instance L1 = L1
*   instance C1 = C1

.temp 26.85
.options TNOM=26.85 RELTOL=0.001 VNTOL=1E-06 ABSTOL=1E-12 METHOD=TRAP
VS in 0 DC 0 PULSE(0 1 1E-08 1E-09 1E-09 9.999999999999999E-06 3.9999999999999996E-05) ; VS
R1 in a 5 ; R1
L1 a b 1E-06 ; L1
C1 b 0 1E-09 ; C1
.tran 1E-09 2E-06 0 1E-09
.save v(in) v(a) v(b)
.control
run
linearize
write rlc.raw
.endc
.end
